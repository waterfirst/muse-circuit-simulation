* GW service job: H=4.0000us f=250.0kHz VGH=8.0 VGL=-9.0 clock=continuous frames=2 hold=100.0us output=low_pulse T=25.0C
.model mT1 ptft_fit W=8u L=6u VT0=2.305752757586326 U0=65.000 SS=0.3000 GOFF=1.0000e-14 POL=1
.model mT2 ptft_fit W=8u L=6u VT0=2.305752757586326 U0=65.000 SS=0.3000 GOFF=1.0000e-14 POL=1
.model mT3 ptft_fit W=4u L=4.5u VT0=2.305752757586326 U0=65.000 SS=0.3000 GOFF=1.0000e-14 POL=1
.model mT4 ptft_fit W=4u L=12u VT0=2.305752757586326 U0=65.000 SS=0.3000 GOFF=1.0000e-14 POL=1
.model mT5 ptft_fit W=4u L=4.5u VT0=2.305752757586326 U0=65.000 SS=0.3000 GOFF=1.0000e-14 POL=1
.model mT6 ptft_fit W=4u L=4.5u VT0=2.305752757586326 U0=65.000 SS=0.3000 GOFF=1.0000e-14 POL=1
.model mT7 ptft_fit W=4u L=4.5u VT0=2.305752757586326 U0=65.000 SS=0.3000 GOFF=1.0000e-14 POL=1
.model mT8 ptft_fit W=4u L=4.5u VT0=2.305752757586326 U0=65.000 SS=0.3000 GOFF=1.0000e-14 POL=1
.model mT9 ptft_fit W=56u L=4.5u VT0=2.305752757586326 U0=65.000 SS=0.3000 GOFF=1.0000e-14 POL=1
.model mT10 ptft_fit W=144u L=4.5u VT0=2.305752757586326 U0=65.000 SS=0.3000 GOFF=1.0000e-14 POL=1
.model mT11 ptft_fit W=8u L=4.5u VT0=2.305752757586326 U0=65.000 SS=0.3000 GOFF=1.0000e-14 POL=1
.model mT12 ptft_fit W=8u L=4.5u VT0=2.305752757586326 U0=65.000 SS=0.3000 GOFF=1.0000e-14 POL=1
.model mT13 ptft_fit W=4u L=6u VT0=2.305752757586326 U0=65.000 SS=0.3000 GOFF=1.0000e-14 POL=1
.model mT14 ptft_fit W=8u L=4.5u VT0=2.305752757586326 U0=65.000 SS=0.3000 GOFF=1.0000e-14 POL=1
.model mT15 ptft_fit W=8u L=6u VT0=2.305752757586326 U0=65.000 SS=0.3000 GOFF=1.0000e-14 POL=1
.model mT16 ptft_fit W=8u L=4.5u VT0=2.305752757586326 U0=65.000 SS=0.3000 GOFF=1.0000e-14 POL=1
.subckt gw IN CKA CKB ESR OUT VGH VGL
* TFT lines: N<name> D G S model
N_T1 Q CKB IN mT1
N_T2 A QB VGH mT2
N_T3 A A CKA mT3
N_T4 QB Q CKB mT4
N_T5 VGL CKB QB mT5
N_T6 C CKA B mT6
N_T7 B N1 CKA mT7
N_T8 C Q VGH mT8
N_T9 OUT C VGH mT9
N_T10 OUT N2 VGL mT10
N_T11 N1 VGL QB mT11
N_T12 N2 VGL Q mT12
N_T13 Q ESR VGH mT13
N_T14 N2 N3 N3 mT14
N_T15 N4 CKB IN mT15
N_T16 N3 VGL N4 mT16
C1 VGH C 0.1p
C2 N1 C 0.1p
C3 N4 N3 1p
C4 OUT 0 5p
.ends
VGH VGH 0 8.0
VGL VGL 0 -9.0
VFLM FLM 0 PULSE(8 -9 160u 0.05u 0.05u 2.95u 120u)
VCLK1 CLK1 0 PULSE(8 -9 8u 0.05u 0.05u 2.95u 8u)
VCLK2 CLK2 0 PULSE(8 -9 4u 0.05u 0.05u 2.95u 8u)
VESR ESR 0 PWL(0.0000u -9.0 80.0000u -9.0 80.0500u 8.0)
X1 FLM CLK2 CLK1 ESR OUT1 VGH VGL gw
X2 OUT1 CLK1 CLK2 ESR OUT2 VGH VGL gw
X3 OUT2 CLK2 CLK1 ESR OUT3 VGH VGL gw
X4 OUT3 CLK1 CLK2 ESR OUT4 VGH VGL gw
X5 OUT4 CLK2 CLK1 ESR OUT5 VGH VGL gw
X6 OUT5 CLK1 CLK2 ESR OUT6 VGH VGL gw
.options method=gear reltol=1e-4 abstol=1e-12 vntol=1e-6 gmin=1e-12
.control
set num_threads=1
pre_osdi ptft_fit.osdi
tran 10n 400u 0 20n
set wr_singlescale
set wr_vecnames
set numdgt=15
wrdata out.txt v(FLM) v(CLK1) v(CLK2) v(ESR) v(OUT1) v(OUT2) v(OUT3) v(OUT4) v(OUT5) v(OUT6) v(x1.a) v(x1.b) v(x1.c) v(x1.n1) v(x1.n2) v(x1.n3) v(x1.n4) v(x1.q) v(x1.qb)
.endc
.end
