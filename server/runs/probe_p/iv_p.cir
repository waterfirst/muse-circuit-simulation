* one-device IV probe, POL=1 (p-type): S=VDD 5V, D=0V via ammeter, G swept
.model pt ptft_fit W=8u L=4.5u VT0=1.1 U0=65.00 POL=1
Np d g s pt
Vs s 0 5
Vd d 0 0
Vg g 0 0
.options method=gear reltol=1e-6 abstol=1e-14 gmin=1e-14
.control
pre_osdi ../../ptft_fit.osdi
dc Vg 5 -2 -0.2
set wr_singlescale
wrdata iv_p.txt v(g) i(Vd)
.endc
.end
