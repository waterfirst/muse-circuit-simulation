* gw-react driver job preset=EM H=4.000us f=250.0kHz VGH=8.0 VGL=-9.5 mode=continuous pol=high_pulse W=4.0H
.model mT1 ptft_fit W=8u L=4.5u VT0=1.9000 U0=39.000 POL=1 SS=0.3000 GOFF=1.000e-14
.model mT2 ptft_fit W=8u L=4.5u VT0=1.9000 U0=39.000 POL=1 SS=0.3000 GOFF=1.000e-14
.model mT3 ptft_fit W=4u L=4.5u VT0=1.9000 U0=39.000 POL=1 SS=0.3000 GOFF=1.000e-14
.model mT4 ptft_fit W=40u L=4.5u VT0=1.9000 U0=39.000 POL=1 SS=0.3000 GOFF=1.000e-14
.model mT5 ptft_fit W=20u L=4.5u VT0=1.9000 U0=39.000 POL=1 SS=0.3000 GOFF=1.000e-14
.model mT6 ptft_fit W=8u L=4.5u VT0=1.9000 U0=39.000 POL=1 SS=0.3000 GOFF=1.000e-14
.model mT7 ptft_fit W=4u L=4.5u VT0=1.9000 U0=39.000 POL=1 SS=0.3000 GOFF=1.000e-14
.model mT8 ptft_fit W=4u L=4.5u VT0=1.9000 U0=39.000 POL=1 SS=0.3000 GOFF=1.000e-14
.model mT9 ptft_fit W=4u L=4.5u VT0=1.9000 U0=39.000 POL=1 SS=0.3000 GOFF=1.000e-14
.model mT10 ptft_fit W=4u L=4.5u VT0=1.9000 U0=39.000 POL=1 SS=0.3000 GOFF=1.000e-14
.model mT11 ptft_fit W=4u L=4.5u VT0=1.9000 U0=39.000 POL=1 SS=0.3000 GOFF=1.000e-14
.model mT12 ptft_fit W=8u L=4.5u VT0=1.9000 U0=39.000 POL=1 SS=0.3000 GOFF=1.000e-14
.subckt gstage IN CKA CKB OUT VGH VGL
N_T1 N7 N2 VGH mT1
N_T2 N3 CKB N7 mT2
N_T3 N3 VGL N1 mT3
N_T4 OUT N4 VGH mT4
N_T5 VGL N3 OUT mT5
N_T6 N1 CKA IN mT6
N_T7 CKA N1 N2 mT7
N_T8 VGL CKA N2 mT8
N_T9 N5 VGL N2 mT9
N_T10 N4 CKB N6 mT10
N_T11 CKB N5 N6 mT11
N_T12 N4 N1 VGH mT12
C1 N3 CKB 0.3p
C2 N5 N6 0.3p
C3 VGH N4 1.0p
CL OUT 0 1.0p
.ends
VGH VGH 0 8.0
VGL VGL 0 -9.5
VFLM FLM 0 PWL(0.0000u -9.5 38.0000u -9.5 38.0500u 8.0 54.0000u 8.0 54.0500u -9.5 134.0000u -9.5 134.0500u 8.0 150.0000u 8.0 150.0500u -9.5)
VCLK1 CLK1 0 PWL(0.0000u 8.0 8.0000u 8.0 8.0500u -9.5 11.0000u -9.5 11.0500u 8.0 16.0000u 8.0 16.0500u -9.5 19.0000u -9.5 19.0500u 8.0 24.0000u 8.0 24.0500u -9.5 27.0000u -9.5 27.0500u 8.0 32.0000u 8.0 32.0500u -9.5 35.0000u -9.5 35.0500u 8.0 40.0000u 8.0 40.0500u -9.5 43.0000u -9.5 43.0500u 8.0 48.0000u 8.0 48.0500u -9.5 51.0000u -9.5 51.0500u 8.0 56.0000u 8.0 56.0500u -9.5 59.0000u -9.5 59.0500u 8.0 64.0000u 8.0 64.0500u -9.5 67.0000u -9.5 67.0500u 8.0 72.0000u 8.0 72.0500u -9.5 75.0000u -9.5 75.0500u 8.0 80.0000u 8.0 80.0500u -9.5 83.0000u -9.5 83.0500u 8.0 88.0000u 8.0 88.0500u -9.5 91.0000u -9.5 91.0500u 8.0 96.0000u 8.0 96.0500u -9.5 99.0000u -9.5 99.0500u 8.0 104.0000u 8.0 104.0500u -9.5 107.0000u -9.5 107.0500u 8.0 112.0000u 8.0 112.0500u -9.5 115.0000u -9.5 115.0500u 8.0 120.0000u 8.0 120.0500u -9.5 123.0000u -9.5 123.0500u 8.0 128.0000u 8.0 128.0500u -9.5 131.0000u -9.5 131.0500u 8.0 136.0000u 8.0 136.0500u -9.5 139.0000u -9.5 139.0500u 8.0 144.0000u 8.0 144.0500u -9.5 147.0000u -9.5 147.0500u 8.0 152.0000u 8.0 152.0500u -9.5 155.0000u -9.5 155.0500u 8.0 160.0000u 8.0 160.0500u -9.5 163.0000u -9.5 163.0500u 8.0 168.0000u 8.0 168.0500u -9.5 171.0000u -9.5 171.0500u 8.0 176.0000u 8.0 176.0500u -9.5 179.0000u -9.5 179.0500u 8.0 184.0000u 8.0 184.0500u -9.5 187.0000u -9.5 187.0500u 8.0 192.0000u 8.0 192.0500u -9.5 195.0000u -9.5 195.0500u 8.0 200.0000u 8.0 200.0500u -9.5 203.0000u -9.5 203.0500u 8.0 208.0000u 8.0 208.0500u -9.5 211.0000u -9.5 211.0500u 8.0 216.0000u 8.0 216.0500u -9.5 219.0000u -9.5 219.0500u 8.0 224.0000u 8.0 224.0500u -9.5 227.0000u -9.5 227.0500u 8.0)
VCLK2 CLK2 0 PWL(0.0000u 8.0 12.0000u 8.0 12.0500u -9.5 15.0000u -9.5 15.0500u 8.0 20.0000u 8.0 20.0500u -9.5 23.0000u -9.5 23.0500u 8.0 28.0000u 8.0 28.0500u -9.5 31.0000u -9.5 31.0500u 8.0 36.0000u 8.0 36.0500u -9.5 39.0000u -9.5 39.0500u 8.0 44.0000u 8.0 44.0500u -9.5 47.0000u -9.5 47.0500u 8.0 52.0000u 8.0 52.0500u -9.5 55.0000u -9.5 55.0500u 8.0 60.0000u 8.0 60.0500u -9.5 63.0000u -9.5 63.0500u 8.0 68.0000u 8.0 68.0500u -9.5 71.0000u -9.5 71.0500u 8.0 76.0000u 8.0 76.0500u -9.5 79.0000u -9.5 79.0500u 8.0 84.0000u 8.0 84.0500u -9.5 87.0000u -9.5 87.0500u 8.0 92.0000u 8.0 92.0500u -9.5 95.0000u -9.5 95.0500u 8.0 100.0000u 8.0 100.0500u -9.5 103.0000u -9.5 103.0500u 8.0 108.0000u 8.0 108.0500u -9.5 111.0000u -9.5 111.0500u 8.0 116.0000u 8.0 116.0500u -9.5 119.0000u -9.5 119.0500u 8.0 124.0000u 8.0 124.0500u -9.5 127.0000u -9.5 127.0500u 8.0 132.0000u 8.0 132.0500u -9.5 135.0000u -9.5 135.0500u 8.0 140.0000u 8.0 140.0500u -9.5 143.0000u -9.5 143.0500u 8.0 148.0000u 8.0 148.0500u -9.5 151.0000u -9.5 151.0500u 8.0 156.0000u 8.0 156.0500u -9.5 159.0000u -9.5 159.0500u 8.0 164.0000u 8.0 164.0500u -9.5 167.0000u -9.5 167.0500u 8.0 172.0000u 8.0 172.0500u -9.5 175.0000u -9.5 175.0500u 8.0 180.0000u 8.0 180.0500u -9.5 183.0000u -9.5 183.0500u 8.0 188.0000u 8.0 188.0500u -9.5 191.0000u -9.5 191.0500u 8.0 196.0000u 8.0 196.0500u -9.5 199.0000u -9.5 199.0500u 8.0 204.0000u 8.0 204.0500u -9.5 207.0000u -9.5 207.0500u 8.0 212.0000u 8.0 212.0500u -9.5 215.0000u -9.5 215.0500u 8.0 220.0000u 8.0 220.0500u -9.5 223.0000u -9.5 223.0500u 8.0 228.0000u 8.0 228.0500u -9.5 231.0000u -9.5 231.0500u 8.0)
X1 FLM CLK1 CLK2 OUT1 VGH VGL gstage
X2 OUT1 CLK2 CLK1 OUT2 VGH VGL gstage
X3 OUT2 CLK1 CLK2 OUT3 VGH VGL gstage
X4 OUT3 CLK2 CLK1 OUT4 VGH VGL gstage
.options method=gear reltol=1e-4 abstol=1e-12 vntol=1e-6 gmin=1e-12
.control
pre_osdi ptft_fit.osdi
tran 10n 232.000u 0 20n
set wr_singlescale
set wr_vecnames
wrdata out.txt v(FLM) v(CLK1) v(CLK2) v(OUT1) v(OUT2) v(OUT3) v(OUT4) v(x1.n1) v(x1.n2) v(x1.n3) v(x1.n4) v(x1.n5) v(x1.n6) v(x1.n7)
.endc
.end
