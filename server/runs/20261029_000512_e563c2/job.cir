* gw-react 8T1C pixel DATA=4.0 frame=8333us
.model mT1 ptft_fit W=3u L=6u VT0=1.1000 U0=65.000 POL=1 SS=0.3000 GOFF=1.000e-14
N_T1 ND NG NS mT1
.model mT2 ptft_fit W=3u L=4.5u VT0=1.1000 U0=65.000 POL=1 SS=0.3000 GOFF=1.000e-14
N_T2 NS GW DATA mT2
.model mT3 ptft_fit W=3u L=4.5u VT0=1.1000 U0=65.000 POL=-1 SS=0.3000 GOFF=1.000e-14
N_T3 ND GC NG mT3
.model mT4 ptft_fit W=3u L=4.5u VT0=1.1000 U0=65.000 POL=-1 SS=0.3000 GOFF=1.000e-14
N_T4 NG GI VINT mT4
.model mT5 ptft_fit W=6u L=4.5u VT0=1.1000 U0=65.000 POL=1 SS=0.3000 GOFF=1.000e-14
N_T5 NS EM ELVDD mT5
.model mT6 ptft_fit W=6u L=4.5u VT0=1.1000 U0=65.000 POL=1 SS=0.3000 GOFF=1.000e-14
N_T6 ANODE EM ND mT6
.model mT7 ptft_fit W=3u L=4.5u VT0=1.1000 U0=65.000 POL=1 SS=0.3000 GOFF=1.000e-14
N_T7 ANODE GW VINT mT7
.model mT8 ptft_fit W=3u L=4.5u VT0=1.1000 U0=65.000 POL=1 SS=0.3000 GOFF=1.000e-14
N_T8 NS GO VOBS mT8
Cst NG ELVDD 0.2p
Coled ANODE ELVSS 1.0p
.model oled D(IS=1e-15 N=1.2 RS=300K)
Doled ANODE N_OLED oled
Vsense N_OLED ELVSS 0
VELVDD ELVDD 0 4.6
VELVSS ELVSS 0 0.0
VVINT VINT 0 -2.0
VVOBS VOBS 0 5.0
VDATA DATA 0 4.0
VVGH VGH 0 8.0
VVGL VGL 0 -9.5
VGI GI 0 PWL(0.000u -9.5 0.000u -9.5 0.100u 8.0 30.000u 8.0 30.100u -9.5 8333.333u -9.5 8333.433u 8.0 8363.333u 8.0 8363.433u -9.5)
VGC GC 0 PWL(0.000u -9.5 80.000u -9.5 80.100u 8.0 110.000u 8.0 110.100u -9.5 8413.333u -9.5 8413.433u 8.0 8443.333u 8.0 8443.433u -9.5)
VGW GW 0 PWL(0.000u 8.0 80.000u 8.0 80.100u -9.5 110.000u -9.5 110.100u 8.0 8413.333u 8.0 8413.433u -9.5 8443.333u -9.5 8443.433u 8.0)
VEM EM 0 PWL(0.000u 8.0 150.000u 8.0 150.100u -9.5 8300.000u -9.5 8300.100u 8.0 8483.333u 8.0 8483.433u -9.5 16633.333u -9.5 16633.433u 8.0)
VGO GO 0 PWL(0.000u 8.0 40.000u 8.0 40.100u -9.5 70.000u -9.5 70.100u 8.0 8373.333u 8.0 8373.433u -9.5 8403.333u -9.5 8403.433u 8.0)
.options method=gear reltol=1e-4 abstol=1e-13 vntol=1e-6 gmin=1e-12
.control
pre_osdi ptft_fit.osdi
tran 50n 16666.67u 0 1u
set wr_singlescale
set wr_vecnames
wrdata out.txt v(GI) v(GC) v(GW) v(EM) v(GO) v(NG) v(NS) v(ND) v(ANODE) v(DATA) i(Vsense)
.endc
.end
