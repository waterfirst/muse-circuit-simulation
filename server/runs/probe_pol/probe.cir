* one-device N polarity probe POL=-1
.model mn ptft_fit W=8u L=4.5u VT0=1.100 U0=65.00 POL=-1
.model mp ptft_fit W=8u L=4.5u VT0=1.100 U0=65.00 POL=1
VDD dn 0 8
VGn gn 0 0
N1 dn gn 0 mn
VDDp dp 0 8
VGp gp 0 8
N2 dp gp 8 mp
.options method=gear reltol=1e-4 abstol=1e-12 gmin=1e-12
.control
pre_osdi ptft_fit.osdi
dc VGn -2 8 0.5
print v(dn) v(gn) i(VDD)
.endc
.end
