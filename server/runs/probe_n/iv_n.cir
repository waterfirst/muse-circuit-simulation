* one-device IV probe, POL=-1 (n-type): S=0V, D=5V via ammeter, G swept
.model nt ptft_fit W=8u L=4.5u VT0=1.1 U0=65.00 POL=-1
Nn d g s nt
Vs s 0 0
Vd d 0 5
Vg g 0 0
.options method=gear reltol=1e-6 abstol=1e-14 gmin=1e-14
.control
pre_osdi ../../ptft_fit.osdi
dc Vg -2 5 0.2
set wr_singlescale
wrdata iv_n.txt v(g) i(Vd)
.endc
.end
