* gw-react driver job preset=GW H=4.000us f=250.0kHz VGH=4.0 VGL=-14.0 mode=continuous pol=low_pulse W=1.0H
.model mT1 ptft_fit W=8u L=4.5u VT0=3.1000 U0=6.500 POL=1 SS=0.9000 GOFF=1.000e-12
.model mT2 ptft_fit W=4u L=6u VT0=3.1000 U0=6.500 POL=1 SS=0.9000 GOFF=1.000e-12
.model mT3 ptft_fit W=4u L=4.5u VT0=3.1000 U0=6.500 POL=1 SS=0.9000 GOFF=1.000e-12
.model mT4 ptft_fit W=4u L=4.5u VT0=3.1000 U0=6.500 POL=1 SS=0.9000 GOFF=1.000e-12
.model mT5 ptft_fit W=4u L=6u VT0=3.1000 U0=6.500 POL=1 SS=0.9000 GOFF=1.000e-12
.model mT6 ptft_fit W=40u L=4.5u VT0=3.1000 U0=6.500 POL=1 SS=0.9000 GOFF=1.000e-12
.model mT7 ptft_fit W=4u L=4.5u VT0=3.1000 U0=6.500 POL=1 SS=0.9000 GOFF=1.000e-12
.model mT8 ptft_fit W=4u L=4.5u VT0=3.1000 U0=6.500 POL=1 SS=0.9000 GOFF=1.000e-12
.model mT9 ptft_fit W=4u L=4.5u VT0=3.1000 U0=6.500 POL=1 SS=0.9000 GOFF=1.000e-12
.subckt gstage IN CKA CKB OUT VGH VGL
N_T1 B CKA IN mT1
N_T2 A C VGH mT2
N_T3 B CKB A mT3
N_T4 C B VGH mT4
N_T5 VGL CKA QB mT5
N_T6 OUT QB VGH mT6
N_T7 CKB Q OUT mT7
N_T8 Q VGL B mT8
N_T9 C CKB QB mT9
C1 VGH QB 1.0p
C2 OUT Q 0.2p
CL OUT 0 1.0p
.ends
VGH VGH 0 4.0
VGL VGL 0 -14.0
VFLM FLM 0 PWL(0.0000u 4.0 39.5000u 4.0 39.5500u -14.0 43.5000u -14.0 43.5500u 4.0 127.5000u 4.0 127.5500u -14.0 131.5000u -14.0 131.5500u 4.0)
VCLK1 CLK1 0 PWL(0.0000u 4.0 8.0000u 4.0 8.0500u -14.0 11.0000u -14.0 11.0500u 4.0 16.0000u 4.0 16.0500u -14.0 19.0000u -14.0 19.0500u 4.0 24.0000u 4.0 24.0500u -14.0 27.0000u -14.0 27.0500u 4.0 32.0000u 4.0 32.0500u -14.0 35.0000u -14.0 35.0500u 4.0 40.0000u 4.0 40.0500u -14.0 43.0000u -14.0 43.0500u 4.0 48.0000u 4.0 48.0500u -14.0 51.0000u -14.0 51.0500u 4.0 56.0000u 4.0 56.0500u -14.0 59.0000u -14.0 59.0500u 4.0 64.0000u 4.0 64.0500u -14.0 67.0000u -14.0 67.0500u 4.0 72.0000u 4.0 72.0500u -14.0 75.0000u -14.0 75.0500u 4.0 80.0000u 4.0 80.0500u -14.0 83.0000u -14.0 83.0500u 4.0 88.0000u 4.0 88.0500u -14.0 91.0000u -14.0 91.0500u 4.0 96.0000u 4.0 96.0500u -14.0 99.0000u -14.0 99.0500u 4.0 104.0000u 4.0 104.0500u -14.0 107.0000u -14.0 107.0500u 4.0 112.0000u 4.0 112.0500u -14.0 115.0000u -14.0 115.0500u 4.0 120.0000u 4.0 120.0500u -14.0 123.0000u -14.0 123.0500u 4.0 128.0000u 4.0 128.0500u -14.0 131.0000u -14.0 131.0500u 4.0 136.0000u 4.0 136.0500u -14.0 139.0000u -14.0 139.0500u 4.0 144.0000u 4.0 144.0500u -14.0 147.0000u -14.0 147.0500u 4.0 152.0000u 4.0 152.0500u -14.0 155.0000u -14.0 155.0500u 4.0 160.0000u 4.0 160.0500u -14.0 163.0000u -14.0 163.0500u 4.0 168.0000u 4.0 168.0500u -14.0 171.0000u -14.0 171.0500u 4.0 176.0000u 4.0 176.0500u -14.0 179.0000u -14.0 179.0500u 4.0 184.0000u 4.0 184.0500u -14.0 187.0000u -14.0 187.0500u 4.0 192.0000u 4.0 192.0500u -14.0 195.0000u -14.0 195.0500u 4.0 200.0000u 4.0 200.0500u -14.0 203.0000u -14.0 203.0500u 4.0 208.0000u 4.0 208.0500u -14.0 211.0000u -14.0 211.0500u 4.0)
VCLK2 CLK2 0 PWL(0.0000u 4.0 12.0000u 4.0 12.0500u -14.0 15.0000u -14.0 15.0500u 4.0 20.0000u 4.0 20.0500u -14.0 23.0000u -14.0 23.0500u 4.0 28.0000u 4.0 28.0500u -14.0 31.0000u -14.0 31.0500u 4.0 36.0000u 4.0 36.0500u -14.0 39.0000u -14.0 39.0500u 4.0 44.0000u 4.0 44.0500u -14.0 47.0000u -14.0 47.0500u 4.0 52.0000u 4.0 52.0500u -14.0 55.0000u -14.0 55.0500u 4.0 60.0000u 4.0 60.0500u -14.0 63.0000u -14.0 63.0500u 4.0 68.0000u 4.0 68.0500u -14.0 71.0000u -14.0 71.0500u 4.0 76.0000u 4.0 76.0500u -14.0 79.0000u -14.0 79.0500u 4.0 84.0000u 4.0 84.0500u -14.0 87.0000u -14.0 87.0500u 4.0 92.0000u 4.0 92.0500u -14.0 95.0000u -14.0 95.0500u 4.0 100.0000u 4.0 100.0500u -14.0 103.0000u -14.0 103.0500u 4.0 108.0000u 4.0 108.0500u -14.0 111.0000u -14.0 111.0500u 4.0 116.0000u 4.0 116.0500u -14.0 119.0000u -14.0 119.0500u 4.0 124.0000u 4.0 124.0500u -14.0 127.0000u -14.0 127.0500u 4.0 132.0000u 4.0 132.0500u -14.0 135.0000u -14.0 135.0500u 4.0 140.0000u 4.0 140.0500u -14.0 143.0000u -14.0 143.0500u 4.0 148.0000u 4.0 148.0500u -14.0 151.0000u -14.0 151.0500u 4.0 156.0000u 4.0 156.0500u -14.0 159.0000u -14.0 159.0500u 4.0 164.0000u 4.0 164.0500u -14.0 167.0000u -14.0 167.0500u 4.0 172.0000u 4.0 172.0500u -14.0 175.0000u -14.0 175.0500u 4.0 180.0000u 4.0 180.0500u -14.0 183.0000u -14.0 183.0500u 4.0 188.0000u 4.0 188.0500u -14.0 191.0000u -14.0 191.0500u 4.0 196.0000u 4.0 196.0500u -14.0 199.0000u -14.0 199.0500u 4.0 204.0000u 4.0 204.0500u -14.0 207.0000u -14.0 207.0500u 4.0 212.0000u 4.0 212.0500u -14.0 215.0000u -14.0 215.0500u 4.0)
X1 FLM CLK1 CLK2 OUT1 VGH VGL gstage
X2 OUT1 CLK2 CLK1 OUT2 VGH VGL gstage
X3 OUT2 CLK1 CLK2 OUT3 VGH VGL gstage
X4 OUT3 CLK2 CLK1 OUT4 VGH VGL gstage
.options method=gear reltol=1e-4 abstol=1e-12 vntol=1e-6 gmin=1e-12
.control
pre_osdi ptft_fit.osdi
tran 10n 216.000u 0 20n
set wr_singlescale
set wr_vecnames
wrdata out.txt v(FLM) v(CLK1) v(CLK2) v(OUT1) v(OUT2) v(OUT3) v(OUT4) v(x1.a) v(x1.b) v(x1.c) v(x1.q) v(x1.qb)
.endc
.end
