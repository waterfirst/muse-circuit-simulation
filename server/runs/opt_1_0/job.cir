* gw-react driver job preset=GW10T2C H=4.000us f=250.0kHz VGH=8.0 VGL=-9.5 mode=continuous pol=low_pulse W=1.0H
.model mT1 ptft_fit W=6u L=4u VT0=1.1000 U0=65.000 POL=1 SS=0.3000 GOFF=1.000e-14
.model mT2 ptft_fit W=6u L=4u VT0=1.1000 U0=65.000 POL=1 SS=0.3000 GOFF=1.000e-14
.model mT3 ptft_fit W=6u L=4u VT0=1.1000 U0=65.000 POL=1 SS=0.3000 GOFF=1.000e-14
.model mT4 ptft_fit W=60u L=4u VT0=1.1000 U0=65.000 POL=1 SS=0.3000 GOFF=1.000e-14
.model mT5 ptft_fit W=12u L=4u VT0=1.1000 U0=65.000 POL=1 SS=0.3000 GOFF=1.000e-14
.model mT6 ptft_fit W=6u L=4u VT0=1.1000 U0=65.000 POL=1 SS=0.3000 GOFF=1.000e-14
.model mT7 ptft_fit W=100u L=4u VT0=1.1000 U0=65.000 POL=1 SS=0.3000 GOFF=1.000e-14
.model mT8 ptft_fit W=12u L=4u VT0=1.1000 U0=65.000 POL=1 SS=0.3000 GOFF=1.000e-14
.model mT9 ptft_fit W=200u L=4u VT0=1.1000 U0=65.000 POL=1 SS=0.3000 GOFF=1.000e-14
.model mT10 ptft_fit W=300u L=4u VT0=1.1000 U0=65.000 POL=-1 SS=0.3000 GOFF=1.000e-14
.subckt gstage IN CKA CKB OUT VGH VGL
N_T1 Q2 CKA IN mT1
N_T2 A QB VGH mT2
N_T3 Q2 CKB A mT3
N_T4 QB Q2 CKA mT4
N_T5 Q CKA QB mT5
N_T6 B QB VGH mT6
N_T7 B Q CKB mT7
N_T8 Q VGL Q2 mT8
N_T9 OUT B VGH mT9
N_T10 VGL B OUT mT10
C1 VGH QB 1.0p
C2 Q B 2.0p
CL OUT 0 1.0p
.ends
VGH VGH 0 8.0
VGL VGL 0 -9.5
VFLM FLM 0 PWL(0.0000u 8.0 39.5000u 8.0 39.5500u -9.5 43.5000u -9.5 43.5500u 8.0 135.5000u 8.0 135.5500u -9.5 139.5000u -9.5 139.5500u 8.0)
VCLK1 CLK1 0 PWL(0.0000u 8.0 8.0000u 8.0 8.0500u -9.5 11.0000u -9.5 11.0500u 8.0 16.0000u 8.0 16.0500u -9.5 19.0000u -9.5 19.0500u 8.0 24.0000u 8.0 24.0500u -9.5 27.0000u -9.5 27.0500u 8.0 32.0000u 8.0 32.0500u -9.5 35.0000u -9.5 35.0500u 8.0 40.0000u 8.0 40.0500u -9.5 43.0000u -9.5 43.0500u 8.0 48.0000u 8.0 48.0500u -9.5 51.0000u -9.5 51.0500u 8.0 56.0000u 8.0 56.0500u -9.5 59.0000u -9.5 59.0500u 8.0 64.0000u 8.0 64.0500u -9.5 67.0000u -9.5 67.0500u 8.0 72.0000u 8.0 72.0500u -9.5 75.0000u -9.5 75.0500u 8.0 80.0000u 8.0 80.0500u -9.5 83.0000u -9.5 83.0500u 8.0 88.0000u 8.0 88.0500u -9.5 91.0000u -9.5 91.0500u 8.0 96.0000u 8.0 96.0500u -9.5 99.0000u -9.5 99.0500u 8.0 104.0000u 8.0 104.0500u -9.5 107.0000u -9.5 107.0500u 8.0 112.0000u 8.0 112.0500u -9.5 115.0000u -9.5 115.0500u 8.0 120.0000u 8.0 120.0500u -9.5 123.0000u -9.5 123.0500u 8.0 128.0000u 8.0 128.0500u -9.5 131.0000u -9.5 131.0500u 8.0 136.0000u 8.0 136.0500u -9.5 139.0000u -9.5 139.0500u 8.0 144.0000u 8.0 144.0500u -9.5 147.0000u -9.5 147.0500u 8.0 152.0000u 8.0 152.0500u -9.5 155.0000u -9.5 155.0500u 8.0 160.0000u 8.0 160.0500u -9.5 163.0000u -9.5 163.0500u 8.0 168.0000u 8.0 168.0500u -9.5 171.0000u -9.5 171.0500u 8.0 176.0000u 8.0 176.0500u -9.5 179.0000u -9.5 179.0500u 8.0 184.0000u 8.0 184.0500u -9.5 187.0000u -9.5 187.0500u 8.0 192.0000u 8.0 192.0500u -9.5 195.0000u -9.5 195.0500u 8.0 200.0000u 8.0 200.0500u -9.5 203.0000u -9.5 203.0500u 8.0 208.0000u 8.0 208.0500u -9.5 211.0000u -9.5 211.0500u 8.0 216.0000u 8.0 216.0500u -9.5 219.0000u -9.5 219.0500u 8.0 224.0000u 8.0 224.0500u -9.5 227.0000u -9.5 227.0500u 8.0)
VCLK2 CLK2 0 PWL(0.0000u 8.0 16.0000u 8.0 16.0500u -9.5 19.0000u -9.5 19.0500u 8.0 26.0000u 8.0 26.0500u -9.5 29.0000u -9.5 29.0500u 8.0 36.0000u 8.0 36.0500u -9.5 39.0000u -9.5 39.0500u 8.0 46.0000u 8.0 46.0500u -9.5 49.0000u -9.5 49.0500u 8.0 56.0000u 8.0 56.0500u -9.5 59.0000u -9.5 59.0500u 8.0)
X1 FLM CLK1 CLK2 OUT1 VGH VGL gstage
X2 OUT1 CLK2 CLK1 OUT2 VGH VGL gstage
X3 OUT2 CLK1 CLK2 OUT3 VGH VGL gstage
X4 OUT3 CLK2 CLK1 OUT4 VGH VGL gstage
X5 OUT4 CLK1 CLK2 OUT5 VGH VGL gstage
X6 OUT5 CLK2 CLK1 OUT6 VGH VGL gstage
.options method=gear reltol=1e-4 abstol=1e-12 vntol=1e-6 gmin=1e-12
.control
pre_osdi ptft_fit.osdi
tran 10n 232.000u 0 20n
set wr_singlescale
set wr_vecnames
wrdata out.txt v(FLM) v(CLK1) v(CLK2) v(OUT1) v(OUT2) v(OUT3) v(OUT4) v(OUT5) v(OUT6) v(x1.a) v(x1.b) v(x1.q) v(x1.q2) v(x1.qb)
.endc
.end
